# Ansys Electronics Desktop project, version 2016.0
materials:
  vacuum: permittivity=1

design RL_template_165v (HFSS, DrivenModal, model units mm)
variables:
  X1 = 66.0079mm
  Y1 = 0.5mm
  Z1 = 0mm
  X2 = 50.0979mm
  Y2 = 0.5mm
  Z2 = 0mm
  X3 = 31.2931mm
  Y3 = 4.0408mm
  Z3 = 0mm
  X4 = 47.9mm
  Y4 = 13.5125mm
  Z4 = 0mm
  X5 = 62.9417mm
  Y5 = 18.6963mm
  Z5 = 0mm
  X6 = 62.6159mm
  Y6 = 19.6417mm
  Z6 = 0mm
  X7 = 47.5742mm
  Y7 = 14.4579mm
  Z7 = 0mm
  X8 = 28.676mm
  Y8 = 11.6347mm
  Z8 = 0mm
  X9 = 41.943mm
  Y9 = 26.4156mm
  Z9 = 0mm
  X10 = 54.3101mm
  Y10 = 36.4246mm
  Z10 = 0mm
  X11 = 53.681mm
  Y11 = 37.2019mm
  Z11 = 0mm
  X12 = 41.3139mm
  Y12 = 27.1929mm
  Z12 = 0mm
  X13 = 25.3742mm
  Y13 = 18.3361mm
  Z13 = 0mm
  X14 = 36.3662mm
  Y14 = 34.7335mm
  Z14 = 0mm
  X15 = 47.232mm
  Y15 = 46.355mm
  Z15 = 0mm
  X16 = 46.5016mm
  Y16 = 47.038mm
  Z16 = 0mm
  X17 = 35.6357mm
  Y17 = 35.4164mm
  Z17 = 0mm
  X18 = 20.9666mm
  Y18 = 24.3681mm
  Z18 = 0mm
  X19 = 19.3915mm
  Y19 = 43.5885mm
  Z19 = 0mm
  X20 = 21.2264mm
  Y20 = 59.3922mm
  Z20 = 0mm
  X21 = 20.2331mm
  Y21 = 59.5076mm
  Z21 = 0mm
  X22 = 18.3981mm
  Y22 = 43.7038mm
  Z22 = 0mm
  X23 = 12.4896mm
  Y23 = 25.6015mm
  Z23 = 0mm
  X24 = -2.1136mm
  Y24 = 36.8055mm
  Z24 = 0mm
  X25 = -12.5217mm
  Y25 = 48.8386mm
  Z25 = 0mm
  X26 = -13.278mm
  Y26 = 48.1844mm
  Z26 = 0mm
  X27 = -2.8699mm
  Y27 = 36.1513mm
  Z27 = 0mm
  X28 = 7.1072mm
  Y28 = 18.9374mm
  Z28 = 0mm
  X29 = -13.062mm
  Y29 = 21.2432mm
  Z29 = 0mm
  X30 = -27.4813mm
  Y30 = 27.9671mm
  Z30 = 0mm
  X31 = -27.9039mm
  Y31 = 27.0608mm
  Z31 = 0mm
  X32 = -13.4846mm
  Y32 = 20.3369mm
  Z32 = 0mm
  X33 = 0.42002mm
  Y33 = 6.8567mm
  Z33 = 0mm
  X34 = -18.3461mm
  Y34 = 0.5mm
  Z34 = 0mm
  X35 = -34.256mm
  Y35 = 0.5mm
  Z35 = 0mm
geometry:
  Polyline1 = polyline((X1, Y1, Z1) (X2, Y2, Z2) (X3, Y3, Z3) (X4, Y4, Z4) (X5, Y5, Z5) (X6, Y6, Z6) (X7, Y7, Z7) (X8, Y8, Z8) (X9, Y9, Z9) (X10, Y10, Z10) (X11, Y11, Z11) (X12, Y12, Z12) (X13, Y13, Z13) (X14, Y14, Z14) (X15, Y15, Z15) (X16, Y16, Z16) (X17, Y17, Z17) (X18, Y18, Z18) (X19, Y19, Z19) (X20, Y20, Z20) (X21, Y21, Z21) (X22, Y22, Z22) (X23, Y23, Z23) (X24, Y24, Z24) (X25, Y25, Z25) (X26, Y26, Z26) (X27, Y27, Z27) (X28, Y28, Z28) (X29, Y29, Z29) (X30, Y30, Z30) (X31, Y31, Z31) (X32, Y32, Z32) (X33, Y33, Z33) (X34, Y34, Z34) (X35, Y35, Z35) (X35, -Y35, Z35) (X34, -Y34, Z34) (X33, -Y33, Z33) (X32, -Y32, Z32) (X31, -Y31, Z31) (X30, -Y30, Z30) (X29, -Y29, Z29) (X28, -Y28, Z28) (X27, -Y27, Z27) (X26, -Y26, Z26) (X25, -Y25, Z25) (X24, -Y24, Z24) (X23, -Y23, Z23) (X22, -Y22, Z22) (X21, -Y21, Z21) (X20, -Y20, Z20) (X19, -Y19, Z19) (X18, -Y18, Z18) (X17, -Y17, Z17) (X16, -Y16, Z16) (X15, -Y15, Z15) (X14, -Y14, Z14) (X13, -Y13, Z13) (X12, -Y12, Z12) (X11, -Y11, Z11) (X10, -Y10, Z10) (X9, -Y9, Z9) (X8, -Y8, Z8) (X7, -Y7, Z7) (X6, -Y6, Z6) (X5, -Y5, Z5) (X4, -Y4, Z4) (X3, -Y3, Z3) (X2, -Y2, Z2) (X1, -Y1, Z1), closed, covered)
