# Ansys Electronics Desktop project, version 2016.0
materials:
  vacuum: permittivity=1

design RL_template_165v (HFSS, DrivenModal, model units mm)
variables:
  X1 = 94.873mm
  Y1 = 0.5mm
  Z1 = 0mm
  X2 = 93.9336mm
  Y2 = 0.5mm
  Z2 = 0mm
  X3 = 31.2853mm
  Y3 = 4.044mm
  Z3 = 0mm
  X4 = 88.2662mm
  Y4 = 30.2612mm
  Z4 = 0mm
  X5 = 89.1404mm
  Y5 = 30.6049mm
  Z5 = 0mm
  X6 = 88.7745mm
  Y6 = 31.5355mm
  Z6 = 0mm
  X7 = 87.9003mm
  Y7 = 31.1918mm
  Z7 = 0mm
  X8 = 28.3481mm
  Y8 = 11.5143mm
  Z8 = 0mm
  X9 = 77.3056mm
  Y9 = 51.201mm
  Z9 = 0mm
  X10 = 78.0463mm
  Y10 = 51.7787mm
  Z10 = 0mm
  X11 = 77.4313mm
  Y11 = 52.5672mm
  Z11 = 0mm
  X12 = 76.6906mm
  Y12 = 51.9895mm
  Z12 = 0mm
  X13 = 26.8901mm
  Y13 = 14.6494mm
  Z13 = 0mm
  X14 = 73.952mm
  Y14 = 56.5376mm
  Z14 = 0mm
  X15 = 74.6653mm
  Y15 = 57.1488mm
  Z15 = 0mm
  X16 = 74.0146mm
  Y16 = 57.9082mm
  Z16 = 0mm
  X17 = 73.3013mm
  Y17 = 57.297mm
  Z17 = 0mm
  X18 = 25.2542mm
  Y18 = 17.6956mm
  Z18 = 0mm
  X19 = 69.3153mm
  Y19 = 62.6903mm
  Z19 = 0mm
  X20 = 69.9852mm
  Y20 = 63.3488mm
  Z20 = 0mm
  X21 = 69.2842mm
  Y21 = 64.0619mm
  Z21 = 0mm
  X22 = 68.6143mm
  Y22 = 63.4034mm
  Z22 = 0mm
  X23 = 23.3602mm
  Y23 = 20.5969mm
  Z23 = 0mm
  X24 = 62.0267mm
  Y24 = 70.2432mm
  Z24 = 0mm
  X25 = 62.618mm
  Y25 = 70.9731mm
  Z25 = 0mm
  X26 = 61.841mm
  Y26 = 71.6026mm
  Z26 = 0mm
  X27 = 61.2497mm
  Y27 = 70.8727mm
  Z27 = 0mm
  X28 = 21.0763mm
  Y28 = 23.2025mm
  Z28 = 0mm
  X29 = 45.324mm
  Y29 = 81.2061mm
  Z29 = 0mm
  X30 = 45.7085mm
  Y30 = 82.0632mm
  Z30 = 0mm
  X31 = 44.7961mm
  Y31 = 82.4725mm
  Z31 = 0mm
  X32 = 44.4116mm
  Y32 = 81.6155mm
  Z32 = 0mm
  X33 = 17.3883mm
  Y33 = 25.3495mm
  Z33 = 0mm
  X34 = 7.9796mm
  Y34 = 87.2153mm
  Z34 = 0mm
  X35 = 7.8626mm
  Y35 = 88.1473mm
  Z35 = 0mm
  X36 = 6.8704mm
  Y36 = 88.0228mm
  Z36 = 0mm
  X37 = 6.9874mm
  Y37 = 87.0908mm
  Z37 = 0mm
  X38 = 13.1727mm
  Y38 = 24.6863mm
  Z38 = 0mm
  X39 = -21.3008mm
  Y39 = 76.6444mm
  Z39 = 0mm
  X40 = -21.8007mm
  Y40 = 77.4397mm
  Z40 = 0mm
  X41 = -22.6473mm
  Y41 = 76.9074mm
  Z41 = 0mm
  X42 = -22.1473mm
  Y42 = 76.1122mm
  Z42 = 0mm
  X43 = 10.0389mm
  Y43 = 22.0385mm
  Z43 = 0mm
  X44 = -38.8813mm
  Y44 = 60.4403mm
  Z44 = 0mm
  X45 = -39.6059mm
  Y45 = 61.038mm
  Z45 = 0mm
  X46 = -40.2422mm
  Y46 = 60.2665mm
  Z46 = 0mm
  X47 = -39.5176mm
  Y47 = 59.6688mm
  Z47 = 0mm
  X48 = 8.1832mm
  Y48 = 18.3796mm
  Z48 = 0mm
  X49 = -52.4523mm
  Y49 = 39.6113mm
  Z49 = 0mm
  X50 = -53.3036mm
  Y50 = 40.0082mm
  Z50 = 0mm
  X51 = -53.7262mm
  Y51 = 39.1019mm
  Z51 = 0mm
  X52 = -52.8749mm
  Y52 = 38.7049mm
  Z52 = 0mm
  X53 = 0mm
  Y53 = 7.0058mm
  Z53 = 0mm
  X54 = -62.6224mm
  Y54 = 0.5mm
  Z54 = 0mm
  X55 = -63.5618mm
  Y55 = 0.5mm
  Z55 = 0mm
geometry:
  Polyline1 = polyline((X1, Y1, Z1) (X2, Y2, Z2) (X3, Y3, Z3) (X4, Y4, Z4) (X5, Y5, Z5) (X6, Y6, Z6) (X7, Y7, Z7) (X8, Y8, Z8) (X9, Y9, Z9) (X10, Y10, Z10) (X11, Y11, Z11) (X12, Y12, Z12) (X13, Y13, Z13) (X14, Y14, Z14) (X15, Y15, Z15) (X16, Y16, Z16) (X17, Y17, Z17) (X18, Y18, Z18) (X19, Y19, Z19) (X20, Y20, Z20) (X21, Y21, Z21) (X22, Y22, Z22) (X23, Y23, Z23) (X24, Y24, Z24) (X25, Y25, Z25) (X26, Y26, Z26) (X27, Y27, Z27) (X28, Y28, Z28) (X29, Y29, Z29) (X30, Y30, Z30) (X31, Y31, Z31) (X32, Y32, Z32) (X33, Y33, Z33) (X34, Y34, Z34) (X35, Y35, Z35) (X36, Y36, Z36) (X37, Y37, Z37) (X38, Y38, Z38) (X39, Y39, Z39) (X40, Y40, Z40) (X41, Y41, Z41) (X42, Y42, Z42) (X43, Y43, Z43) (X44, Y44, Z44) (X45, Y45, Z45) (X46, Y46, Z46) (X47, Y47, Z47) (X48, Y48, Z48) (X49, Y49, Z49) (X50, Y50, Z50) (X51, Y51, Z51) (X52, Y52, Z52) (X53, Y53, Z53) (X54, Y54, Z54) (X55, Y55, Z55) (X55, -Y55, Z55) (X54, -Y54, Z54) (X53, -Y53, Z53) (X52, -Y52, Z52) (X51, -Y51, Z51) (X50, -Y50, Z50) (X49, -Y49, Z49) (X48, -Y48, Z48) (X47, -Y47, Z47) (X46, -Y46, Z46) (X45, -Y45, Z45) (X44, -Y44, Z44) (X43, -Y43, Z43) (X42, -Y42, Z42) (X41, -Y41, Z41) (X40, -Y40, Z40) (X39, -Y39, Z39) (X38, -Y38, Z38) (X37, -Y37, Z37) (X36, -Y36, Z36) (X35, -Y35, Z35) (X34, -Y34, Z34) (X33, -Y33, Z33) (X32, -Y32, Z32) (X31, -Y31, Z31) (X30, -Y30, Z30) (X29, -Y29, Z29) (X28, -Y28, Z28) (X27, -Y27, Z27) (X26, -Y26, Z26) (X25, -Y25, Z25) (X24, -Y24, Z24) (X23, -Y23, Z23) (X22, -Y22, Z22) (X21, -Y21, Z21) (X20, -Y20, Z20) (X19, -Y19, Z19) (X18, -Y18, Z18) (X17, -Y17, Z17) (X16, -Y16, Z16) (X15, -Y15, Z15) (X14, -Y14, Z14) (X13, -Y13, Z13) (X12, -Y12, Z12) (X11, -Y11, Z11) (X10, -Y10, Z10) (X9, -Y9, Z9) (X8, -Y8, Z8) (X7, -Y7, Z7) (X6, -Y6, Z6) (X5, -Y5, Z5) (X4, -Y4, Z4) (X3, -Y3, Z3) (X2, -Y2, Z2) (X1, -Y1, Z1), closed, covered)
