# Ansys Electronics Desktop project, version 2016.0
materials:
  vacuum: permittivity=1

design HFSSDesign1 (HFSS, DrivenModal, model units mm)
variables:
  X1 = 127.2795mm
  Y1 = 0.5mm
  Z1 = 0mm
  X2 = 111.3696mm
  Y2 = 0.5mm
  Z2 = 0mm
  X3 = 63.6364mm
  Y3 = 3.995mm
  Z3 = 0mm
  X4 = 109.8568mm
  Y4 = 16.4057mm
  Z4 = 0mm
  X5 = 125.4828mm
  Y5 = 19.3983mm
  Z5 = 0mm
  X6 = 125.2947mm
  Y6 = 20.3805mm
  Z6 = 0mm
  X7 = 109.6687mm
  Y7 = 17.3879mm
  Z7 = 0mm
  X8 = 62.1368mm
  Y8 = 11.8255mm
  Z8 = 0mm
  X9 = 76.0251mm
  Y9 = 62.4506mm
  Z9 = 0mm
  X10 = 84.6465mm
  Y10 = 75.8222mm
  Z10 = 0mm
  X11 = 83.806mm
  Y11 = 76.3641mm
  Z11 = 0mm
  X12 = 75.1846mm
  Y12 = 62.9925mm
  Z12 = 0mm
  X13 = 37.3447mm
  Y13 = 33.3883mm
  Z13 = 0mm
  X14 = 11.2779mm
  Y14 = 75.3772mm
  Z14 = 0mm
  X15 = 7.6819mm
  Y15 = 90.8754mm
  Z15 = 0mm
  X16 = 6.7078mm
  Y16 = 90.6494mm
  Z16 = 0mm
  X17 = 10.3038mm
  Y17 = 75.1512mm
  Z17 = 0mm
  X18 = 5.8128mm
  Y18 = 24.1507mm
  Z18 = 0mm
  X19 = -43.0677mm
  Y19 = 29.1098mm
  Z19 = 0mm
  X20 = -58.4355mm
  Y20 = 33.2276mm
  Z20 = 0mm
  X21 = -58.6943mm
  Y21 = 32.2617mm
  Z21 = 0mm
  X22 = -43.3265mm
  Y22 = 28.1439mm
  Z22 = 0mm
  X23 = -4.4159e-16mm
  Y23 = 8.3963mm
  Z23 = 0mm
  X24 = -47.7298mm
  Y24 = 0.5mm
  Z24 = 0mm
  X25 = -63.6398mm
  Y25 = 0.5mm
  Z25 = 0mm
geometry:
  Polyline1 = polyline((X1, Y1, Z1) (X2, Y2, Z2) (X3, Y3, Z3) (X4, Y4, Z4) (X5, Y5, Z5) (X6, Y6, Z6) (X7, Y7, Z7) (X8, Y8, Z8) (X9, Y9, Z9) (X10, Y10, Z10) (X11, Y11, Z11) (X12, Y12, Z12) (X13, Y13, Z13) (X14, Y14, Z14) (X15, Y15, Z15) (X16, Y16, Z16) (X17, Y17, Z17) (X18, Y18, Z18) (X19, Y19, Z19) (X20, Y20, Z20) (X21, Y21, Z21) (X22, Y22, Z22) (X23, Y23, Z23) (X24, Y24, Z24) (X25, Y25, Z25) (X25, -Y25, Z25) (X24, -Y24, Z24) (X23, -Y23, Z23) (X22, -Y22, Z22) (X21, -Y21, Z21) (X20, -Y20, Z20) (X19, -Y19, Z19) (X18, -Y18, Z18) (X17, -Y17, Z17) (X16, -Y16, Z16) (X15, -Y15, Z15) (X14, -Y14, Z14) (X13, -Y13, Z13) (X12, -Y12, Z12) (X11, -Y11, Z11) (X10, -Y10, Z10) (X9, -Y9, Z9) (X8, -Y8, Z8) (X7, -Y7, Z7) (X6, -Y6, Z6) (X5, -Y5, Z5) (X4, -Y4, Z4) (X3, -Y3, Z3) (X2, -Y2, Z2) (X1, -Y1, Z1), closed, covered)
